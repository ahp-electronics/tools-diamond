| IBIS File
| Lattice Semiconductor Corporation
[IBIS Ver]   4.2
[File name]   lifmd.ibs
[File rev]   2.2
[Date]   Wed Jul 11 18:26:08 PDT 2018
[Source]   Lattice Semiconductor umc40lp Process
[Notes]   Device: LIF-MD6000   Preliminary
   Device: LIA-MD6000   Preliminary
   Lattice Semiconductor has worked hard to ensure the
   models below are accurate and complete.  However, the
   data below was generated using simulation of the
   input/output model files for the silicon.  Therefore,
   the data below is for reference and initial design
   purposes only.
   Lattice Semiconductor grants permission to use this
   data for use in printed circuit design using this
   Lattice programmable logic device.  Other use of this
   code, including the selling or duplication of any
   portion is strictly prohibited.
|   NAMING CONVENTION
   The IBIS [Model] header is limited by the specification to a
   total of characters.  With such a set of characters available
   for naming models it becomes important to attempt to
   meaningfully encode the IO standards so they fit within the
   twenty character limit.  It would seem that twenty characters
   would provide room enough for describing IO's.  However, the
   PLD IO structure continues to grow more and more complex.  The
   complexity is making the twenty characters insuffiently
   descriptive.  In order to overcome this issue the naming
   convention described below is implemented to resolve the issue.
The twenty character space is managed as follows:
   bbbvvvsdddprtaaaoixx
   b = standard
   v = voltage (x.xx V)
   s = slew code
   d = drive (xx.x ma)
   p = pullmode code
   r = impedance
   t = mipi hard dphy mode
   a = unused or not available
   o = diff resistor code
   i = diff  current code
   x = reserved
   standard
   LVCMOS   lvc
   lvcmosd   lvd
   LVTTL   lvt
   lvttld   ltd
   lvds   lvs
   sublvds   slv
   slvs   svs
   mipi   mip
   slew
   na   a
   fast   f
   slow   s
   pullmode
   off   a
   pull up   b
   3p3k   i
   6p8k   j
   10k   k
   impedance
   off   a
   mipi hard dphy mode
   off   a
   lp   l
   hs   h
   differential resistor
   off   a
   100   b
   differential current
   NA   a
   3.5   c
   Reserved   IO type
   in   input only (mipi: rx)
   ou   output (mipi: tx)
   io   I/O
   od   Open drain
   on   Inverting differential I/O
   (signal name only)
   op   Non-Inverting differential I/O
   (signal name only)
   Lattice Semiconductor Corporation
   5555 NE Moore Court
   Hillsboro, OR 97214
   U.S.A
   TEL: 1-800-Lattice (USA and Canada)
   408-826-6000 (other locations)
   web: http://www.latticesemi.com/
   email: techsupport@latticesemi.com
The IBIS models by default includes the worst case package data
under [package].  If detailed package model is required , it can be
enable using [package model] keyword.
The .pkg files are included in the zip file with the IBIS models.
The .pkg file has to be located in the same directory as IBIS file.
[Disclaimer] This IBIS source code is intended as a design reference
   which illustrates how the Lattice Semiconductor device operates.
   It is the user's responsibility to verify their design for
   consistency and functionality through the use of formal
   verification methods.  Lattice Semiconductor provides no warranty
   regarding the use or functionality of this data.
[Copyright]   Copyright 2015 by Lattice Semiconductor Corporation
|   Component LIFMD
[Component]   LIFMD
[Manufacturer]   Lattice Semiconductor Corp.
[Package]
|CTFBGA80
| variable   typ   min   max
|R_pkg   144.360m   14.366m   221.160m
|L_pkg   1.9200nH   0.2595nH   2.6330nH
|C_pkg   0.3261pF   0.1794pF   1.7020pF
|CKFBGA80
| variable   typ   min   max
|R_pkg   164.7m   95.584m   220.49m
|L_pkg   1.53nH   0.8748nH   1.98nH
|C_pkg   0.7937pF   0.5599pF   0.9311pF
|CSFBGA81
| variable   typ   min   max
R_pkg   84.890m   15.155m   139.180m
L_pkg   1.1430nH   0.1667nH   1.6950nH
C_pkg   0.2490pF   0.1302pF   1.0720pF
|UCFBGA64
| variable   typ   min   max
|R_pkg   61.058m   18.526m   203.120m
|L_pkg   0.7464nH   0.1790nH   2.8510nH
|C_pkg   0.1780pF   0.1230pF   0.3352pF
|WLCSP36
| variable   typ   min   max
|R_pkg   291.220m   40.591m   563.790m
|L_pkg   0.5450nH   0.1240nH   1.7370nH
|C_pkg   0.2944pF   0.1749pF   0.3947pF
[Pin]  signal_name   model_name   R_pin   L_pin   C_pin
1   ltd330a080aaaaaaaaop   ltd330a080aaaaaaaaou
2   ltd330a080aaaaaaaaon   ltd330a080aaaaaaaaou
3   lvc120a020aaaaaaaaio   lvc120a020aaaaaaaaio
4   lvc120a020aaaaaaaaod   lvc120a020aaaaaaaaod
5   lvc120a020aaaaaaaaou   lvc120a020aaaaaaaaou
6   lvc120axxxaaaaaaaain   lvc120axxxaaaaaaaain
7   lvc120axxxbaaaaaaain   lvc120axxxbaaaaaaain
8   lvc180a040aaaaaaaaio   lvc180a040aaaaaaaaio
9   lvc180a040aaaaaaaaod   lvc180a040aaaaaaaaod
10  lvc180a040aaaaaaaaou   lvc180a040aaaaaaaaou
11  lvc180a040baaaaaaaio   lvc180a040baaaaaaaio
12  lvc180a040iaaaaaaaio   lvc180a040iaaaaaaaio
13  lvc180a040jaaaaaaaio   lvc180a040jaaaaaaaio
14  lvc180a040kaaaaaaaio   lvc180a040kaaaaaaaio
15  lvc180axxxaaaaaaaain   lvc180axxxaaaaaaaain
16  lvc180axxxbaaaaaaain   lvc180axxxbaaaaaaain
17  lvc180axxxiaaaaaaain   lvc180axxxiaaaaaaain
18  lvc180axxxjaaaaaaain   lvc180axxxjaaaaaaain
19  lvc180axxxkaaaaaaain   lvc180axxxkaaaaaaain
20  lvc250a060aaaaaaaaio   lvc250a060aaaaaaaaio
21  lvc250a060aaaaaaaaod   lvc250a060aaaaaaaaod
22  lvc250a060aaaaaaaaou   lvc250a060aaaaaaaaou
23  lvc250a060baaaaaaaio   lvc250a060baaaaaaaio
24  lvc250a060iaaaaaaaio   lvc250a060iaaaaaaaio
25  lvc250a060jaaaaaaaio   lvc250a060jaaaaaaaio
26  lvc250a060kaaaaaaaio   lvc250a060kaaaaaaaio
27  lvc250axxxaaaaaaaain   lvc250axxxaaaaaaaain
28  lvc250axxxbaaaaaaain   lvc250axxxbaaaaaaain
29  lvc250axxxiaaaaaaain   lvc250axxxiaaaaaaain
30  lvc250axxxjaaaaaaain   lvc250axxxjaaaaaaain
31  lvc250axxxkaaaaaaain   lvc250axxxkaaaaaaain
32  lvc330a080aaaaaaaaio   lvc330a080aaaaaaaaio
33  lvc330a080aaaaaaaaod   lvc330a080aaaaaaaaod
34  lvc330a080aaaaaaaaou   lvc330a080aaaaaaaaou
35  lvc330a080baaaaaaaio   lvc330a080baaaaaaaio
36  lvc330a080iaaaaaaaio   lvc330a080iaaaaaaaio
37  lvc330a080jaaaaaaaio   lvc330a080jaaaaaaaio
38  lvc330a080kaaaaaaaio   lvc330a080kaaaaaaaio
39  lvc330axxxaaaaaaaain   lvc330axxxaaaaaaaain
40  lvc330axxxbaaaaaaain   lvc330axxxbaaaaaaain
41  lvc330axxxiaaaaaaain   lvc330axxxiaaaaaaain
42  lvc330axxxjaaaaaaain   lvc330axxxjaaaaaaain
43  lvc330axxxkaaaaaaain   lvc330axxxkaaaaaaain
44  lvd250a060aaaaaaaaio   lvd250a060aaaaaaaaio
45  lvd250a060aaaaaaaaop   lvd250a060aaaaaaaaou
46  lvd250a060aaaaaaaaon   lvd250a060aaaaaaaaou
47  lvd250axxxaaaaaaaain   lvd250axxxaaaaaaaain
48  lvd330a080aaaaaaaaop   lvd330a080aaaaaaaaou
49  lvd330a080aaaaaaaaon   lvd330a080aaaaaaaaou
50  lvs250axxxaaaaaaaain   lvs250axxxaaaaaaaain
51  lvs250axxxaaaaaaacop   lvs250axxxaaaaaaacou
52  lvs250axxxaaaaaaacon   lvs250axxxaaaaaaacou
53  lvs250axxxaaaaaabain   lvs250axxxaaaaaabain
54  lvt330a080aaaaaaaaio   lvt330a080aaaaaaaaio
55  lvt330a080aaaaaaaaod   lvt330a080aaaaaaaaod
56  lvt330a080aaaaaaaaou   lvt330a080aaaaaaaaou
57  lvt330a080baaaaaaaio   lvt330a080baaaaaaaio
58  lvt330a080iaaaaaaaio   lvt330a080iaaaaaaaio
59  lvt330a080jaaaaaaaio   lvt330a080jaaaaaaaio
60  lvt330a080kaaaaaaaio   lvt330a080kaaaaaaaio
61  lvt330axxxaaaaaaaain   lvt330axxxaaaaaaaain
62  lvt330axxxbaaaaaaain   lvt330axxxbaaaaaaain
63  lvt330axxxiaaaaaaain   lvt330axxxiaaaaaaain
64  lvt330axxxjaaaaaaain   lvt330axxxjaaaaaaain
65  lvt330axxxkaaaaaaain   lvt330axxxkaaaaaaain
66  mip120a020aaaaaaaaio   mip120a020aaaaaaaaio
67  mip120axxxaaaaaabain   mip120axxxaaaaaabain
68  mip120a020aaaaaaaaou   mip120a020aaaaaaaaou
69  mip120axxxaaaaaaaain   mip120axxxaaaaaaaain
70  slv250axxxaaaaaaaain   slv250axxxaaaaaaaain
71  slv250axxxaaaaaabain   slv250axxxaaaaaabain
72  svs120axxxaaaaaaaain   svs120axxxaaaaaaaain
73  svs120axxxaaaaaabain   svs120axxxaaaaaabain
74  mip120axxxaahaaaaain   mip120axxxaahaaaaain
75  mip120axxxaahaaaaaop   mip120axxxaahaaaaaou
76  mip120axxxaahaaaaaon   mip120axxxaahaaaaaou
77  mip120axxxaalaaaaain   mip120axxxaalaaaaain
78  mip120axxxaalaaaaaou   mip120axxxaalaaaaaou
79  GND   GND
80  POWER   POWER
[Diff pin]  inv_pin  vdiff  tdelay_typ  tdelay_min  tdelay_max
1   2   0.1   0.0s   0.0s   0.0s
45   46   0.1   0.0s   0.0s   0.0s
48   49   0.1   0.0s   0.0s   0.0s
51   52   0.1   0.0s   0.0s   0.0s
75   76   0.1   0.0s   0.0s   0.0s
| Models and submodels in the file (73): ltd330a080aaaaaaaaou (Output), lvc120a020aaaaaaaaio (I/O), lvc120a020aaaaaaaaod (I/O_open_drain), lvc120axxxaaaaaaaain (Input), lvc120axxxbaaaaaaain (Input), lvc120a020aaaaaaaaou (Output), lvc180a040aaaaaaaaio (I/O), lvc180a040aaaaaaaaod (I/O_open_drain), lvc180a040aaaaaaaaou (Output), lvc180a040baaaaaaaio (I/O), lvc180a040iaaaaaaaio (I/O), lvc180a040jaaaaaaaio (I/O), lvc180a040kaaaaaaaio (I/O), lvc180axxxaaaaaaaain (Input), lvc180axxxbaaaaaaain (Input), lvc180axxxiaaaaaaain (Input), lvc180axxxjaaaaaaain (Input), lvc180axxxkaaaaaaain (Input), lvc250a060aaaaaaaaio (I/O), lvc250a060aaaaaaaaod (I/O_open_drain), lvc250a060aaaaaaaaou (Output), lvc250a060baaaaaaaio (I/O), lvc250a060iaaaaaaaio (I/O), lvc250a060jaaaaaaaio (I/O), lvc250a060kaaaaaaaio (I/O), lvc250axxxaaaaaaaain (Input), lvc250axxxbaaaaaaain (Input), lvc250axxxiaaaaaaain (Input), lvc250axxxjaaaaaaain (Input), lvc250axxxkaaaaaaain (Input), lvc330a080aaaaaaaaio (I/O), lvc330a080aaaaaaaaod (I/O_open_drain), lvc330a080aaaaaaaaou (Output), lvc330a080baaaaaaaio (I/O), lvc330a080iaaaaaaaio (I/O), lvc330a080jaaaaaaaio (I/O), lvc330a080kaaaaaaaio (I/O), lvc330axxxaaaaaaaain (Input), lvc330axxxbaaaaaaain (Input), lvc330axxxiaaaaaaain (Input), lvc330axxxjaaaaaaain (Input), lvc330axxxkaaaaaaain (Input), lvd250a060aaaaaaaaio (I/O), lvd250a060aaaaaaaaou (Output), lvd250axxxaaaaaaaain (Input), lvd330a080aaaaaaaaou (Output), lvs250axxxaaaaaaaain (Input), lvs250axxxaaaaaaacou (Output), lvs250axxxaaaaaabain (Input), lvt330a080aaaaaaaaio (I/O), lvt330a080aaaaaaaaod (I/O_open_drain), lvt330a080aaaaaaaaou (Output), lvt330a080baaaaaaaio (I/O), lvt330a080iaaaaaaaio (I/O), lvt330a080jaaaaaaaio (I/O), lvt330a080kaaaaaaaio (I/O), lvt330axxxaaaaaaaain (Input), lvt330axxxbaaaaaaain (Input), lvt330axxxiaaaaaaain (Input), lvt330axxxjaaaaaaain (Input), lvt330axxxkaaaaaaain (Input), mip120a020aaaaaaaaio (I/O), mip120axxxaaaaaabain (Input), mip120a020aaaaaaaaou (Output), mip120axxxaaaaaaaain (Input), slv250axxxaaaaaaaain (Input), slv250axxxaaaaaabain (Input), svs120axxxaaaaaaaain (Input), svs120axxxaaaaaabain (Input), mip120axxxaahaaaaain (Input), mip120axxxaahaaaaaou (Output), mip120axxxaalaaaaain (Input), mip120axxxaalaaaaaou (Output)
